Wattsense bounded fan-start supply scenario startup_no_surge
* ASSUMED equivalent supply; NOT LM2596 component model or selected module.
* Resistive fan demand at 5V: 0.6 A for 0.1 s, then 0.6 A.
* Capacitance includes an assumed external module capacitor, not just PCB C11.
* Fuses remain resistors; no trip or pulse-life claim.
Breg 0 supply I=max(0,min(2.0,(5-v(reg))/0.04))
Vregprobe supply reg 0
Resr reg cap 0.05
Cout cap 0 470u
Rcommon reg rail 0.09548668472936768
Rlampfeed rail lamp 0.09766044841552976
Rlamp lamp 0 8.333333333333334
Icontroller rail 0 0.16
Rfanfeed rail fan 0.2630927291696431
Vfanprobe fan demand 0
Bfan demand 0 I=v(demand)*(time < 0.01 ? 0 : (time < 0.11 ? 0.12 : 0.12))
.options reltol=1e-5
.tran 20u 150m 0 20u
.end
